ADE simulation setup
Run mode: Single Run, Sweeps and Corners
Tests:
  proj3_16bit_FA:16b_ripple_carry_pg:1: proj3_16bit_FA/16b_ripple_carry_pg/schematic, simulator spectre
