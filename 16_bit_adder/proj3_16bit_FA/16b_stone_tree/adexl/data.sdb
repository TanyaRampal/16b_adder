ADE simulation setup
Run mode: Single Run, Sweeps and Corners
Tests:
  proj3_16bit_FA:16b_stone_tree:1: proj3_16bit_FA/16b_stone_tree/schematic, simulator spectre
Global variables:
  vdd = 1.2
