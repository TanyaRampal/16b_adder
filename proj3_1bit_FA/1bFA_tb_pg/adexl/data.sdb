ADE simulation setup
Run mode: Single Run, Sweeps and Corners
Tests:
  proj3_1bit_FA:1bFA_tb:1: proj3_1bit_FA/1bFA_tb_pg/schematic, simulator spectre
