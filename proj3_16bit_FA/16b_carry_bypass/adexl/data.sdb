ADE simulation setup
Run mode: Single Run, Sweeps and Corners
Tests:
  proj3_16bit_FA:16b_carry_bypass:1: proj3_16bit_FA/16b_carry_bypass/schematic, simulator spectre
