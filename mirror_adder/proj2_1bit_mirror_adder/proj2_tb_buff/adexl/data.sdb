ADE simulation setup
Run mode: Single Run, Sweeps and Corners
Tests:
  proj2_1bit_mirror_adder:proj2_tb_buff:1: proj2_1bit_mirror_adder/proj2_tb_buff/schematic, simulator spectre
Global variables:
  Wn = 120n
  Wn_2 = 240n
  Wn_3 = 360n
  Wp = 205.85n
  Wp_2 = 411.7n
  Wp_4 = 823.4n
  Wp_6 = 1235.1n
