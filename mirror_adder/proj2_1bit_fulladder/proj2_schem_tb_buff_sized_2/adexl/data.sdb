ADE simulation setup
Run mode: Single Run, Sweeps and Corners
Tests:
  proj2_1bit_fulladder:proj2_schem_tb_buff_sized:1: proj2_1bit_fulladder/proj2_schem_tb_buff_sized_2/schematic, simulator spectre
Global variables:
  Wp_2 = 411.7n
  Wp_4 = 823.4n
  Wn = 120n
  Wn_2 = 240n
  Wn_3 = 360n
  Wp = 20
  Wp_6 = 1235.1n
  c = 1f
  r = 1.715417
