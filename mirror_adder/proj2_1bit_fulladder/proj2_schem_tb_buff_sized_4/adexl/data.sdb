ADE simulation setup
Run mode: Monte Carlo Sampling
Tests:
  proj2_1bit_fulladder:proj2_schem_tb_buff_sized_4:1: proj2_1bit_fulladder/proj2_schem_tb_buff_sized_4/schematic, simulator spectre
Monte Carlo Sampling options: ignoremode=default, mcmethod=all, mcnumpoints=100
