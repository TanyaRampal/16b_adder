ADE simulation setup
Run mode: Single Run, Sweeps and Corners
Tests:
  proj1_inv:proj1_inv_tb_buff_tp:1: proj1_inv/proj1_inv_tb_buff_tp/schematic, simulator spectre
Global variables:
  Wp = 205n
  Wn = 120n
